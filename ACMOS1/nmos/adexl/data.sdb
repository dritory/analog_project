ADE simulation setup
Run mode: Single Run, Sweeps and Corners
Tests:
  ACMOS1:nmos:1: ACMOS1/nmos/schematic, simulator spectre
    Outputs: getData("NMO:)) "); getData("NMO:vth"); vth
Global variables:
  vgs = {Inclusion List}0{Inclusion List}{From/To}Auto:0:10:1{From/To}
  vsg = 0 (off)
  vds = 0
