ADE simulation setup
Run mode: Single Run, Sweeps and Corners
Tests:
  project:test_OTA_tb:1: project/test_OTA_tb/schematic, simulator spectre
Global variables:
  vdd = 1
  W2 = 1.2u
  Wp2 = 2u
  Cl = 1f
  Lp = 118n
  Lp2 = 181n
  ibias = 10u
  L = 160n
  L2 = 230n
  vcom = 830m
  vb1 = 370m
  W = 420n
  vb2 = 590m
  Wp = 670n
  Wpi = 1 * Wp
  Wc = 10*Wp
